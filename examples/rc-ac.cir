* RC AC Analysis Test
* Simple RC low-pass filter frequency response
V1 in 0 AC 1
R1 in out 1k
C1 out 0 1u
.ac dec 20 1 1e6
.control
run
print vdb(out)
.endc
.end
