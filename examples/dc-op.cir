* DC Operating Point Test
* Simple resistor divider
V1 in 0 DC 5
R1 in out 10k
R2 out 0 2k
.op
.control
run
print v(out)
.endc
.end
